EVT E6 noise_100
.include TLV9062_ngspice.lib
.options reltol=1e-5 vntol=1e-9 abstol=1e-13
.temp 25
Vdd vdd 0 3.3
Vin source 0 DC 1.5 AC 1
Rsrc source inp 100
X1 inp buf vdd 0 buf TLV9062
Cpcb1 buf 0 10p
Rhi buf div 10k
Rlo div 0 20k
Cdiv div 0 5p
X2 div drive vdd 0 drive TLV9062
Cpcb2 drive 0 10p
Riso drive adc 100
Cf adc 0 343p
Rsw adc sample 200 noisy=0
Cs sample 0 15p

.control
set wr_singlescale
set wr_vecnames
set numdgt=12
noise v(sample) Vin dec 150 0.1 100Meg
setplot noise1
wrdata noise_100.dat onoise_spectrum
quit
.endc
.end
