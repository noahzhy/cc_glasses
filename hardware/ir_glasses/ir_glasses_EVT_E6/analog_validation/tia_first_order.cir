EVT E6 tia_first_order
.include TLV9062_ngspice.lib
.options reltol=1e-5 vntol=1e-9 abstol=1e-13
.temp 25
Vdd vdd 0 3.3
Vin source 0 PULSE(0.15 3.1 5u 1n 1n 70u 160u)
Rtia source tiain 100k
Ctia tiain 0 22p
Ebuf inp 0 tiain 0 1
X1 inp buf vdd 0 buf TLV9062
Cpcb1 buf 0 10p
Rhi buf div 10k
Rlo div 0 20k
Cdiv div 0 5p
X2 div drive vdd 0 drive TLV9062
Cpcb2 drive 0 10p
Riso drive adc 100
Cf adc 0 343p
Rsw adc sample 200
Cs sample 0 15p

.control
set wr_singlescale
set wr_vecnames
set numdgt=12
tran 10n 145u 0 10n
wrdata tia_first_order.dat v(source) v(drive) v(adc) v(sample)
quit
.endc
.end
