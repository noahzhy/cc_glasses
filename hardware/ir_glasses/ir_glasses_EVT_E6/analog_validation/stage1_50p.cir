EVT E6 stage1_50p
.include TLV9062_ngspice.lib
.options reltol=1e-5 vntol=1e-9 abstol=1e-13
.temp 25
Vdd vdd 0 3.3
Vin inp 0 1.1
X1 inp inv vdd 0 out TLV9062
Vtest inv out DC 0 AC 1
Rload out 0 30k
Cpcb out 0 50p

.control
set wr_singlescale
set wr_vecnames
set numdgt=12
ac dec 120 1 100Meg
let lg=-v(out)/v(inv)
wrdata stage1_50p.dat real(lg) imag(lg)
quit
.endc
.end
