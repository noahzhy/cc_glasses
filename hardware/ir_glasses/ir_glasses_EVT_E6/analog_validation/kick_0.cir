EVT E6 kick_0
.include TLV9062_ngspice.lib
.options reltol=1e-5 vntol=1e-9 abstol=1e-13
.temp 25
Vdd vdd 0 3.3
Vin source 0 DC 1.5 AC 1
Rsrc source inp 100
X1 inp buf vdd 0 buf TLV9062
Cpcb1 buf 0 10p
Rhi buf div 10k
Rlo div 0 20k
Cdiv div 0 5p
X2 div drive vdd 0 drive TLV9062
Cpcb2 drive 0 10p
Riso drive adc 100
Cf adc 0 343p
Rsw adc sw 200
Sacq sw sample ctrl 0 SAMPLE_SW
Sreset sample rst invctrl 0 SAMPLE_SW
.model SAMPLE_SW SW(Ron=0.01 Roff=1e12 Vt=0.5 Vh=0.01)
Vctrl ctrl 0 PWL(0 0 2u 0 2.001u 1)
Binv invctrl 0 V=1-v(ctrl)
Vrst rst 0 0
Cs sample 0 15p

.control
set wr_singlescale
set wr_vecnames
set numdgt=12
tran 1n 8u 0 1n
wrdata kick_0.dat v(adc) v(sample)
quit
.endc
.end
