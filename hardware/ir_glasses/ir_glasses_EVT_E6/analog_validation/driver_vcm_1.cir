EVT E6 driver_vcm_1
.include TLV9062_ngspice.lib
.options reltol=1e-5 vntol=1e-9 abstol=1e-13
.temp 25
Vdd vdd 0 3.3
Vin inp 0 2.2
X1 inp inv vdd 0 out TLV9062
Vtest inv out DC 0 AC 1
Coutpcb out 0 30p
Riso out adc 100
Cf adc 0 363p
Rsw adc sample 200
Cs sample 0 15p

.control
set wr_singlescale
set wr_vecnames
set numdgt=12
ac dec 120 1 100Meg
let lg=-v(out)/v(inv)
wrdata driver_vcm_1.dat real(lg) imag(lg)
quit
.endc
.end
