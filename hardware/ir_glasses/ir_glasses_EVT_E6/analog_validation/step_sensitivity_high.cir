EVT E6 step_sensitivity_high
.include TLV9062_ngspice.lib
.options reltol=1e-5 vntol=1e-9 abstol=1e-13
.temp -25
Vdd vdd 0 3.399
Vin source 0 PULSE(0.15 3.249 2u 1n 1n 8u 20u)
Rsrc source inp 100
X1 inp buf vdd 0 buf TLV9062
Cpcb1 buf 0 30p
Rhi buf div 10k
Rlo div 0 20k
Cdiv div 0 5p
X2 div drive vdd 0 drive TLV9062
Cpcb2 drive 0 30p
Riso drive adc 101
Cf adc 0 379.5p
Rsw adc sample 200
Cs sample 0 15p

.control
set wr_singlescale
set wr_vecnames
set numdgt=12
tran 2n 18u 0 2n
wrdata step_sensitivity_high.dat v(source) v(drive) v(adc) v(sample)
quit
.endc
.end
