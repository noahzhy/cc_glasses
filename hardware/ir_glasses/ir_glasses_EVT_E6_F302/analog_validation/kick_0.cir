E6 F302 kick_0
.include TLV9062_ngspice.lib
.options reltol=1e-6 vntol=1e-9 abstol=1e-13
.temp 25
Vdd vdd 0 3.3
Vin inp 0 DC 1.65
X1 inp inv vdd 0 drive TLV9062
Vfb inv drive DC 0 AC 0
Cpcb drive 0 30p
Riso drive adc 101
Cf adc 0 383.5p
Rsw adc sw 5000
Sacq sw sample ctrl 0 SWC
Sreset sample rst invctrl 0 SWC
.model SWC SW(Ron=.01 Roff=1e12 Vt=.5 Vh=.01)
Vctrl ctrl 0 PWL(0 0 2u 0 2.001u 1)
Binv invctrl 0 V=1-v(ctrl)
Vrst rst 0 0
Cs sample 0 10p

.control
set wr_singlescale
set wr_vecnames
set numdgt=12
tran 1n 10u 0 1n
wrdata kick_0.dat v(adc) v(sample)
quit
.endc
.end
