E6 F302 noise
.include TLV9062_ngspice.lib
.options reltol=1e-6 vntol=1e-9 abstol=1e-13
.temp 25
Vdd vdd 0 3.3
Vin inp 0 DC 1.65 AC 1
X1 inp inv vdd 0 drive TLV9062
Vfb inv drive DC 0 AC 0
Cpcb drive 0 10p
Riso drive adc 100
Cf adc 0 347p
Rsw adc sample 1000 noisy=0
Cs sample 0 5p

.control
set wr_singlescale
set wr_vecnames
set numdgt=12
noise v(sample) Vin dec 150 0.1 100Meg
setplot noise1
wrdata noise.dat onoise_spectrum
quit
.endc
.end
