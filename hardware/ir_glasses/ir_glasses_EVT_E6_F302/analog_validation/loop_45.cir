E6 F302 loop_45
.include TLV9062_ngspice.lib
.options reltol=1e-6 vntol=1e-9 abstol=1e-13
.temp -25
Vdd vdd 0 3.399
Vin inp 0 DC 1.6995
X1 inp inv vdd 0 drive TLV9062
Vfb inv drive DC 0 AC 1
Cpcb drive 0 30p
Riso drive adc 99
Cf adc 0 383.5p
Rsw adc sample 200
Cs sample 0 10p

.control
set wr_singlescale
set wr_vecnames
set numdgt=12
ac dec 120 1 100Meg
let lg=-v(drive)/v(inv)
wrdata loop_45.dat real(lg) imag(lg)
quit
.endc
.end
